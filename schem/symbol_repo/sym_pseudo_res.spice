** sch_path: /home/zhixuan/projects/fyp_vco/schem/symbol_repo/sym_pseudo_res.sch
.subckt sym_pseudo_res HIGH LOW
XMP_r1 net1 net1 HIGH HIGH sky130_fd_pr__pfet_01v8 L=0.15 W=1 nf=1 ad=0.29 as=0.29 pd=2.58 ps=2.58 nrd=0.29 nrs=0.29 sa=0 sb=0
+ sd=0 mult=1 m=1
XMP_r2 LOW LOW net1 HIGH sky130_fd_pr__pfet_01v8 L=0.15 W=1 nf=1 ad=0.29 as=0.29 pd=2.58 ps=2.58 nrd=0.29 nrs=0.29 sa=0 sb=0 sd=0
+ mult=1 m=1
**.ends
.end

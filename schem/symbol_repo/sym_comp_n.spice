** sch_path: /home/zhixuan/projects/fyp_vco/schem/symbol_repo/sym_comp_n.sch
.subckt comp_n VDD VSS VIN_N VIN_P VOUT BIAS_N
XMP_diode_l net1 net1 VDD VDD sky130_fd_pr__pfet_01v8 L=0.3 W=2 nf=2 ad=0.29 as=0.58 pd=2.58 ps=5.16 nrd=0.145 nrs=0.145 sa=0 sb=0
+ sd=0 mult=1 m=1
XMP_cs_l net2 net1 VDD VDD sky130_fd_pr__pfet_01v8 L=0.3 W=2 nf=2 ad=0.29 as=0.58 pd=2.58 ps=5.16 nrd=0.145 nrs=0.145 sa=0 sb=0
+ sd=0 mult=1 m=1
XMP_cs_r net1 net2 VDD VDD sky130_fd_pr__pfet_01v8 L=0.3 W=2 nf=2 ad=0.29 as=0.58 pd=2.58 ps=5.16 nrd=0.145 nrs=0.145 sa=0 sb=0
+ sd=0 mult=1 m=1
XMP_diode_r net2 net2 VDD VDD sky130_fd_pr__pfet_01v8 L=0.3 W=2 nf=2 ad=0.29 as=0.58 pd=2.58 ps=5.16 nrd=0.145 nrs=0.145 sa=0 sb=0
+ sd=0 mult=1 m=1
XMN_vinn net1 VIN_N net3 VSS sky130_fd_pr__nfet_01v8 L=0.5 W=2.5 nf=1 ad=0.725 as=0.725 pd=5.58 ps=5.58 nrd=0.116 nrs=0.116 sa=0
+ sb=0 sd=0 mult=1 m=1
XMN_vinp net2 VIN_P net3 VSS sky130_fd_pr__nfet_01v8 L=0.5 W=2.5 nf=1 ad=0.725 as=0.725 pd=5.58 ps=5.58 nrd=0.116 nrs=0.116 sa=0
+ sb=0 sd=0 mult=1 m=1
XMN_tail net3 BIAS_N VSS VSS sky130_fd_pr__nfet_01v8 L=0.75 W=2.5 nf=2 ad=0.3625 as=0.725 pd=3.08 ps=6.16 nrd=0.116 nrs=0.116 sa=0
+ sb=0 sd=0 mult=1 m=1
XMP_latch_r VOUT net2 VDD VDD sky130_fd_pr__pfet_01v8 L=0.15 W=0.5 nf=1 ad=0.145 as=0.145 pd=1.58 ps=1.58 nrd=0.58 nrs=0.58 sa=0
+ sb=0 sd=0 mult=1 m=1
XMP_latch_l net5 net1 VDD VDD sky130_fd_pr__pfet_01v8 L=0.15 W=0.5 nf=1 ad=0.145 as=0.145 pd=1.58 ps=1.58 nrd=0.58 nrs=0.58 sa=0
+ sb=0 sd=0 mult=1 m=1
XMN_latch_r VOUT net4 VSS VSS sky130_fd_pr__nfet_01v8 L=0.15 W=0.5 nf=1 ad=0.145 as=0.145 pd=1.58 ps=1.58 nrd=0.58 nrs=0.58 sa=0
+ sb=0 sd=0 mult=1 m=1
XMN_diode_l net4 net4 VSS VSS sky130_fd_pr__nfet_01v8 L=0.15 W=0.5 nf=1 ad=0.145 as=0.145 pd=1.58 ps=1.58 nrd=0.58 nrs=0.58 sa=0
+ sb=0 sd=0 mult=1 m=1
XMP_lim net4 net4 net5 VDD sky130_fd_pr__pfet_01v8 L=0.15 W=0.5 nf=1 ad=0.145 as=0.145 pd=1.58 ps=1.58 nrd=0.58 nrs=0.58 sa=0 sb=0
+ sd=0 mult=1 m=1
**.ends
.end

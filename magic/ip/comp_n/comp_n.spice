* SPICE3 file created from comp_n.ext - technology: sky130A

.subckt sky130_fd_pr__nfet_01v8_57CR37 B D0 G0 S1 G1 D2 G2 S3 G3 a_387_n281#
X0 D2 G1 S1 B sky130_fd_pr__nfet_01v8 ad=0.3625 pd=2.79 as=0.3625 ps=2.79 w=2.5 l=0.75
X1 S3 G2 D2 B sky130_fd_pr__nfet_01v8 ad=0.3625 pd=2.79 as=0.3625 ps=2.79 w=2.5 l=0.75
X2 a_387_n281# G3 S3 B sky130_fd_pr__nfet_01v8 ad=0.725 pd=5.58 as=0.3625 ps=2.79 w=2.5 l=0.75
X3 S1 G0 D0 B sky130_fd_pr__nfet_01v8 ad=0.3625 pd=2.79 as=0.725 ps=5.58 w=2.5 l=0.75
C0 G3 G2 0.05942f
C1 S3 G2 0.04819f
C2 G3 S3 0.04819f
C3 G2 D2 0.04819f
C4 G2 G1 0.05942f
C5 S3 D2 0.17037f
C6 G3 a_387_n281# 0.04819f
C7 S3 a_387_n281# 0.17037f
C8 D0 G0 0.04819f
C9 D2 G1 0.04819f
C10 G1 G0 0.05942f
C11 D0 S1 0.17037f
C12 D2 S1 0.17037f
C13 G1 S1 0.04819f
C14 S1 G0 0.04819f
C15 S3 B 0.08989f
C16 D2 B 0.08989f
C17 S1 B 0.08989f
C18 D0 B 0.31025f
C19 G3 B 0.3887f
C20 G2 B 0.35103f
C21 G1 B 0.35103f
C22 G0 B 0.3887f
C23 a_387_n281# B 0.31025f
.ends

.subckt sky130_fd_pr__nfet_01v8_CTHBRU B D S G
X0 S G D B sky130_fd_pr__nfet_01v8 ad=0.145 pd=1.58 as=0.145 ps=1.58 w=0.5 l=0.15
C0 D G 0.01258f
C1 G S 0.01258f
C2 D S 0.08265f
C3 S B 0.08699f
C4 D B 0.08699f
C5 G B 0.2204f
.ends

.subckt sky130_fd_pr__pfet_01v8_PBPX32 B D0 G0 S1 G1 D2 G2 S3 G3 a_207_n164# VSUBS
X0 S3 G2 D2 B sky130_fd_pr__pfet_01v8 ad=0.29 pd=2.29 as=0.29 ps=2.29 w=2 l=0.3
X1 a_207_n164# G3 S3 B sky130_fd_pr__pfet_01v8 ad=0.58 pd=4.58 as=0.29 ps=2.29 w=2 l=0.3
X2 S1 G0 D0 B sky130_fd_pr__pfet_01v8 ad=0.29 pd=2.29 as=0.58 ps=4.58 w=2 l=0.3
X3 D2 G1 S1 B sky130_fd_pr__pfet_01v8 ad=0.29 pd=2.29 as=0.29 ps=2.29 w=2 l=0.3
C0 G0 D0 0.01864f
C1 D2 S3 0.23983f
C2 D2 G2 0.01864f
C3 B a_207_n164# 0.14858f
C4 G3 a_207_n164# 0.01864f
C5 D2 G1 0.01864f
C6 B G3 0.12079f
C7 B S1 0.02378f
C8 a_207_n164# S3 0.23983f
C9 B G0 0.12079f
C10 B S3 0.02378f
C11 B G2 0.09729f
C12 S1 G0 0.01864f
C13 G3 S3 0.01864f
C14 G3 G2 0.06574f
C15 B G1 0.09729f
C16 S1 G1 0.01864f
C17 G2 S3 0.01864f
C18 G0 G1 0.06574f
C19 B D2 0.02378f
C20 G2 G1 0.06574f
C21 B D0 0.14858f
C22 S1 D2 0.23983f
C23 S1 D0 0.23983f
C24 S3 VSUBS 0.03463f
C25 D2 VSUBS 0.03463f
C26 S1 VSUBS 0.03463f
C27 D0 VSUBS 0.09693f
C28 G3 VSUBS 0.08266f
C29 G2 VSUBS 0.06635f
C30 G1 VSUBS 0.06635f
C31 G0 VSUBS 0.08266f
C32 B VSUBS 2.57151f
C33 a_207_n164# VSUBS 0.09693f
.ends

.subckt sky130_fd_pr__pfet_01v8_FTRNYQ B D S G VSUBS
X0 S G D B sky130_fd_pr__pfet_01v8 ad=0.145 pd=1.58 as=0.145 ps=1.58 w=0.5 l=0.15
C0 B D 0.05535f
C1 S G 0.01172f
C2 G B 0.14521f
C3 S B 0.05535f
C4 G D 0.01172f
C5 S D 0.08265f
C6 S VSUBS 0.03149f
C7 D VSUBS 0.03149f
C8 G VSUBS 0.08082f
C9 B VSUBS 0.92722f
.ends

.subckt sky130_fd_pr__nfet_01v8_GSFB4Z B D0 G0 S1 G1 D2 G2 S3 G3 a_287_n281#
X0 S1 G0 D0 B sky130_fd_pr__nfet_01v8 ad=0.3625 pd=2.79 as=0.725 ps=5.58 w=2.5 l=0.5
X1 a_287_n281# G3 S3 B sky130_fd_pr__nfet_01v8 ad=0.725 pd=5.58 as=0.3625 ps=2.79 w=2.5 l=0.5
X2 S3 G2 D2 B sky130_fd_pr__nfet_01v8 ad=0.3625 pd=2.79 as=0.3625 ps=2.79 w=2.5 l=0.5
X3 D2 G1 S1 B sky130_fd_pr__nfet_01v8 ad=0.3625 pd=2.79 as=0.3625 ps=2.79 w=2.5 l=0.5
C0 S1 G1 0.03486f
C1 G3 a_287_n281# 0.03486f
C2 S3 a_287_n281# 0.2239f
C3 D2 G2 0.03486f
C4 D2 S1 0.2239f
C5 G0 S1 0.03486f
C6 G3 S3 0.03486f
C7 G0 D0 0.03486f
C8 S1 D0 0.2239f
C9 D2 S3 0.2239f
C10 D2 G1 0.03486f
C11 G2 G3 0.05942f
C12 G0 G1 0.05942f
C13 G2 S3 0.03486f
C14 G2 G1 0.05942f
C15 S3 B 0.0761f
C16 D2 B 0.0761f
C17 S1 B 0.0761f
C18 D0 B 0.30335f
C19 G3 B 0.278f
C20 G2 B 0.24056f
C21 G1 B 0.24056f
C22 G0 B 0.278f
C23 a_287_n281# B 0.30335f
.ends

.subckt comp_n VDD VSS VIN_N VIN_P VOUT BIAS_N
Xsky130_fd_pr__nfet_01v8_57CR37_0 VSS VSS VSS VSS BIAS_N sky130_fd_pr__nfet_01v8_GSFB4Z_0/D2
+ BIAS_N VSS VSS VSS sky130_fd_pr__nfet_01v8_57CR37
Xsky130_fd_pr__nfet_01v8_CTHBRU_0 VSS sky130_fd_pr__pfet_01v8_FTRNYQ_1/G VSS sky130_fd_pr__pfet_01v8_FTRNYQ_1/G
+ sky130_fd_pr__nfet_01v8_CTHBRU
Xsky130_fd_pr__nfet_01v8_CTHBRU_1 VSS VSS VOUT sky130_fd_pr__pfet_01v8_FTRNYQ_1/G
+ sky130_fd_pr__nfet_01v8_CTHBRU
Xsky130_fd_pr__pfet_01v8_PBPX32_0 VDD VDD sky130_fd_pr__pfet_01v8_FTRNYQ_2/G sky130_fd_pr__pfet_01v8_FTRNYQ_2/G
+ sky130_fd_pr__pfet_01v8_FTRNYQ_2/G VDD sky130_fd_pr__pfet_01v8_FTRNYQ_2/G sky130_fd_pr__pfet_01v8_FTRNYQ_0/G
+ sky130_fd_pr__pfet_01v8_FTRNYQ_2/G VDD VSS sky130_fd_pr__pfet_01v8_PBPX32
Xsky130_fd_pr__pfet_01v8_PBPX32_1 VDD VDD sky130_fd_pr__pfet_01v8_FTRNYQ_0/G sky130_fd_pr__pfet_01v8_FTRNYQ_2/G
+ sky130_fd_pr__pfet_01v8_FTRNYQ_0/G VDD sky130_fd_pr__pfet_01v8_FTRNYQ_0/G sky130_fd_pr__pfet_01v8_FTRNYQ_0/G
+ sky130_fd_pr__pfet_01v8_FTRNYQ_0/G VDD VSS sky130_fd_pr__pfet_01v8_PBPX32
Xsky130_fd_pr__pfet_01v8_FTRNYQ_0 VDD VDD sky130_fd_pr__pfet_01v8_FTRNYQ_1/S sky130_fd_pr__pfet_01v8_FTRNYQ_0/G
+ VSS sky130_fd_pr__pfet_01v8_FTRNYQ
Xsky130_fd_pr__pfet_01v8_FTRNYQ_1 VDD sky130_fd_pr__pfet_01v8_FTRNYQ_1/G sky130_fd_pr__pfet_01v8_FTRNYQ_1/S
+ sky130_fd_pr__pfet_01v8_FTRNYQ_1/G VSS sky130_fd_pr__pfet_01v8_FTRNYQ
Xsky130_fd_pr__pfet_01v8_FTRNYQ_2 VDD VDD VOUT sky130_fd_pr__pfet_01v8_FTRNYQ_2/G
+ VSS sky130_fd_pr__pfet_01v8_FTRNYQ
Xsky130_fd_pr__nfet_01v8_GSFB4Z_0 VSS VSS VSS sky130_fd_pr__pfet_01v8_FTRNYQ_2/G VIN_P
+ sky130_fd_pr__nfet_01v8_GSFB4Z_0/D2 VIN_N sky130_fd_pr__pfet_01v8_FTRNYQ_0/G VSS
+ VSS sky130_fd_pr__nfet_01v8_GSFB4Z
C0 sky130_fd_pr__nfet_01v8_GSFB4Z_0/D2 sky130_fd_pr__pfet_01v8_FTRNYQ_1/G 0.03839f
C1 sky130_fd_pr__pfet_01v8_FTRNYQ_2/G VDD 0.78291f
C2 VDD VOUT 0.19848f
C3 sky130_fd_pr__pfet_01v8_FTRNYQ_1/S sky130_fd_pr__pfet_01v8_FTRNYQ_1/G 0.00257f
C4 sky130_fd_pr__pfet_01v8_FTRNYQ_0/G BIAS_N 0.00968f
C5 sky130_fd_pr__pfet_01v8_FTRNYQ_2/G VOUT 0.04785f
C6 VDD sky130_fd_pr__pfet_01v8_FTRNYQ_0/G 0.59236f
C7 VIN_P BIAS_N 0.02641f
C8 BIAS_N VIN_N 0.01726f
C9 sky130_fd_pr__nfet_01v8_GSFB4Z_0/D2 BIAS_N 0.12102f
C10 sky130_fd_pr__pfet_01v8_FTRNYQ_1/G BIAS_N 0.01299f
C11 VIN_P VDD 0.01172f
C12 VDD VIN_N 0.18341f
C13 sky130_fd_pr__nfet_01v8_GSFB4Z_0/D2 VDD 0
C14 sky130_fd_pr__pfet_01v8_FTRNYQ_2/G sky130_fd_pr__pfet_01v8_FTRNYQ_0/G 1.08079f
C15 VDD sky130_fd_pr__pfet_01v8_FTRNYQ_1/G 0.26397f
C16 VDD sky130_fd_pr__pfet_01v8_FTRNYQ_1/S 0.45537f
C17 sky130_fd_pr__pfet_01v8_FTRNYQ_2/G VIN_P 0.15177f
C18 sky130_fd_pr__pfet_01v8_FTRNYQ_2/G VIN_N 0.27798f
C19 sky130_fd_pr__pfet_01v8_FTRNYQ_2/G sky130_fd_pr__nfet_01v8_GSFB4Z_0/D2 0.01719f
C20 sky130_fd_pr__pfet_01v8_FTRNYQ_2/G sky130_fd_pr__pfet_01v8_FTRNYQ_1/G 0.32146f
C21 sky130_fd_pr__pfet_01v8_FTRNYQ_1/G VOUT 0.04405f
C22 sky130_fd_pr__pfet_01v8_FTRNYQ_2/G sky130_fd_pr__pfet_01v8_FTRNYQ_1/S 0.00303f
C23 sky130_fd_pr__pfet_01v8_FTRNYQ_1/S VOUT 0.00754f
C24 VDD BIAS_N 0
C25 VIN_P sky130_fd_pr__pfet_01v8_FTRNYQ_0/G 0.00578f
C26 sky130_fd_pr__pfet_01v8_FTRNYQ_0/G VIN_N 0.11856f
C27 sky130_fd_pr__nfet_01v8_GSFB4Z_0/D2 sky130_fd_pr__pfet_01v8_FTRNYQ_0/G 0.00314f
C28 sky130_fd_pr__pfet_01v8_FTRNYQ_1/G sky130_fd_pr__pfet_01v8_FTRNYQ_0/G 0.05238f
C29 sky130_fd_pr__pfet_01v8_FTRNYQ_2/G BIAS_N 0.02662f
C30 sky130_fd_pr__pfet_01v8_FTRNYQ_1/S sky130_fd_pr__pfet_01v8_FTRNYQ_0/G 0.05209f
C31 VIN_P VIN_N 0.3198f
C32 sky130_fd_pr__nfet_01v8_GSFB4Z_0/D2 VIN_P 0.00241f
C33 sky130_fd_pr__nfet_01v8_GSFB4Z_0/D2 VIN_N 0.0102f
C34 VIN_P sky130_fd_pr__pfet_01v8_FTRNYQ_1/G 0.0022f
C35 sky130_fd_pr__pfet_01v8_FTRNYQ_1/G VIN_N 0.00412f
C36 VDD VSS 9.23236f
C37 sky130_fd_pr__nfet_01v8_GSFB4Z_0/D2 VSS 0.3109f
C38 VIN_N VSS 0.29312f
C39 VIN_P VSS 0.42407f
C40 VOUT VSS 0.46369f
C41 sky130_fd_pr__pfet_01v8_FTRNYQ_1/S VSS 0.00687f
C42 sky130_fd_pr__pfet_01v8_FTRNYQ_1/G VSS 1.41254f
C43 sky130_fd_pr__pfet_01v8_FTRNYQ_2/G VSS 1.17626f
C44 sky130_fd_pr__pfet_01v8_FTRNYQ_0/G VSS 0.6327f
C45 BIAS_N VSS 1.17527f
.ends

* SPICE3 file created from comp_p.ext - technology: sky130A

.subckt sky130_fd_pr__pfet_01v8_UFRNYY B D S G VSUBS
X0 S G D B sky130_fd_pr__pfet_01v8 ad=0.145 pd=1.58 as=0.145 ps=1.58 w=0.5 l=0.15
C0 S B 0.05535f
C1 G B 0.14521f
C2 S D 0.08265f
C3 D G 0.01172f
C4 S G 0.01172f
C5 D B 0.05535f
C6 S VSUBS 0.03149f
C7 D VSUBS 0.03149f
C8 G VSUBS 0.08082f
C9 B VSUBS 0.92722f
.ends

.subckt sky130_fd_pr__nfet_01v8_CTHBRU B D S G
X0 S G D B sky130_fd_pr__nfet_01v8 ad=0.145 pd=1.58 as=0.145 ps=1.58 w=0.5 l=0.15
C0 D S 0.08265f
C1 G S 0.01258f
C2 G D 0.01258f
C3 S B 0.08699f
C4 D B 0.08699f
C5 G B 0.2204f
.ends

.subckt sky130_fd_pr__pfet_01v8_57LR5P B D0 G0 S1 G1 D2 G2 S3 G3 D4 G4 S5 G5 D6 S6
+ G6 VSUBS
X0 D4 G3 S3 B sky130_fd_pr__pfet_01v8 ad=0.29 pd=2.29 as=0.29 ps=2.29 w=2 l=0.75
X1 S1 G0 D0 B sky130_fd_pr__pfet_01v8 ad=0.29 pd=2.29 as=0.58 ps=4.58 w=2 l=0.75
X2 D6 G5 S5 B sky130_fd_pr__pfet_01v8 ad=0.29 pd=2.29 as=0.29 ps=2.29 w=2 l=0.75
X3 S5 G4 D4 B sky130_fd_pr__pfet_01v8 ad=0.29 pd=2.29 as=0.29 ps=2.29 w=2 l=0.75
X4 D2 G1 S1 B sky130_fd_pr__pfet_01v8 ad=0.29 pd=2.29 as=0.29 ps=2.29 w=2 l=0.75
X5 S6 G6 D6 B sky130_fd_pr__pfet_01v8 ad=0.58 pd=4.58 as=0.29 ps=2.29 w=2 l=0.75
X6 S3 G2 D2 B sky130_fd_pr__pfet_01v8 ad=0.29 pd=2.29 as=0.29 ps=2.29 w=2 l=0.75
C0 G0 G1 0.0619f
C1 G4 G3 0.0619f
C2 B G1 0.18933f
C3 S1 G1 0.03952f
C4 S6 G6 0.03952f
C5 B S5 0.02376f
C6 G2 G1 0.0619f
C7 G4 D4 0.03952f
C8 G0 D0 0.03952f
C9 B D0 0.14857f
C10 D0 S1 0.13656f
C11 S5 D4 0.13656f
C12 D6 G6 0.03952f
C13 G5 G4 0.0619f
C14 S6 D6 0.13656f
C15 D2 S3 0.13656f
C16 G4 S5 0.03952f
C17 B S3 0.02376f
C18 G5 S5 0.03952f
C19 B G6 0.21258f
C20 G2 S3 0.03952f
C21 B S6 0.14857f
C22 G3 S3 0.03952f
C23 S3 D4 0.13656f
C24 B D6 0.02376f
C25 G5 G6 0.0619f
C26 B D2 0.02376f
C27 D2 S1 0.13656f
C28 B G0 0.21258f
C29 G2 D2 0.03952f
C30 G0 S1 0.03952f
C31 B S1 0.02376f
C32 B G2 0.18917f
C33 B G3 0.18914f
C34 G2 G3 0.0619f
C35 G5 D6 0.03952f
C36 B D4 0.02376f
C37 G3 D4 0.03952f
C38 D6 S5 0.13656f
C39 B G4 0.18917f
C40 B G5 0.18933f
C41 D2 G1 0.03952f
C42 S6 VSUBS 0.10705f
C43 D6 VSUBS 0.05487f
C44 S5 VSUBS 0.05487f
C45 D4 VSUBS 0.05487f
C46 S3 VSUBS 0.05487f
C47 D2 VSUBS 0.05487f
C48 S1 VSUBS 0.05487f
C49 D0 VSUBS 0.10705f
C50 G6 VSUBS 0.18413f
C51 G5 VSUBS 0.16792f
C52 G4 VSUBS 0.16792f
C53 G3 VSUBS 0.16792f
C54 G2 VSUBS 0.16792f
C55 G1 VSUBS 0.16792f
C56 G0 VSUBS 0.18413f
C57 B VSUBS 5.42483f
.ends

.subckt sky130_fd_pr__pfet_01v8_FTRNYQ B D S G VSUBS
X0 S G D B sky130_fd_pr__pfet_01v8 ad=0.145 pd=1.58 as=0.145 ps=1.58 w=0.5 l=0.15
C0 B S 0.05535f
C1 S D 0.08265f
C2 B G 0.14521f
C3 G D 0.01172f
C4 S G 0.01172f
C5 B D 0.05535f
C6 S VSUBS 0.03149f
C7 D VSUBS 0.03149f
C8 G VSUBS 0.08082f
C9 B VSUBS 0.92722f
.ends

.subckt sky130_fd_pr__pfet_01v8_4RRFEZ B D0 G0 S1 G1 D2 G2 S3 G3 D4 G4 S5 G5 a_445_n214#
+ VSUBS
X0 D2 G1 S1 B sky130_fd_pr__pfet_01v8 ad=0.3625 pd=2.79 as=0.3625 ps=2.79 w=2.5 l=0.5
X1 S5 G4 D4 B sky130_fd_pr__pfet_01v8 ad=0.3625 pd=2.79 as=0.3625 ps=2.79 w=2.5 l=0.5
X2 S1 G0 D0 B sky130_fd_pr__pfet_01v8 ad=0.3625 pd=2.79 as=0.725 ps=5.58 w=2.5 l=0.5
X3 D4 G3 S3 B sky130_fd_pr__pfet_01v8 ad=0.3625 pd=2.79 as=0.3625 ps=2.79 w=2.5 l=0.5
X4 a_445_n214# G5 S5 B sky130_fd_pr__pfet_01v8 ad=0.725 pd=5.58 as=0.3625 ps=2.79 w=2.5 l=0.5
X5 S3 G2 D2 B sky130_fd_pr__pfet_01v8 ad=0.3625 pd=2.79 as=0.3625 ps=2.79 w=2.5 l=0.5
C0 S5 G5 0.03486f
C1 G3 B 0.13449f
C2 G3 G4 0.0619f
C3 D0 G0 0.03486f
C4 D4 B 0.02377f
C5 D4 G4 0.03486f
C6 D4 G3 0.03486f
C7 G2 B 0.13449f
C8 G1 G0 0.0619f
C9 D2 B 0.02377f
C10 G3 G2 0.0619f
C11 S1 B 0.02377f
C12 a_445_n214# B 0.17907f
C13 S3 B 0.02377f
C14 S5 B 0.02377f
C15 S5 G4 0.03486f
C16 G2 D2 0.03486f
C17 B G0 0.15762f
C18 G3 S3 0.03486f
C19 S1 D2 0.2239f
C20 G5 B 0.15762f
C21 G5 G4 0.0619f
C22 D0 B 0.17907f
C23 D4 S3 0.2239f
C24 S5 D4 0.2239f
C25 G2 S3 0.03486f
C26 S3 D2 0.2239f
C27 G1 B 0.13462f
C28 a_445_n214# S5 0.2239f
C29 S1 G0 0.03486f
C30 D0 S1 0.2239f
C31 a_445_n214# G5 0.03486f
C32 G2 G1 0.0619f
C33 G1 D2 0.03486f
C34 G4 B 0.13462f
C35 S1 G1 0.03486f
C36 S5 VSUBS 0.05209f
C37 D4 VSUBS 0.05209f
C38 S3 VSUBS 0.05209f
C39 D2 VSUBS 0.05209f
C40 S1 VSUBS 0.05209f
C41 D0 VSUBS 0.12404f
C42 G5 VSUBS 0.12583f
C43 G4 VSUBS 0.10963f
C44 G3 VSUBS 0.10963f
C45 G2 VSUBS 0.10963f
C46 G1 VSUBS 0.10963f
C47 G0 VSUBS 0.12583f
C48 B VSUBS 4.39068f
C49 a_445_n214# VSUBS 0.12404f
.ends

.subckt sky130_fd_pr__nfet_01v8_9DM3XL B D0 G S1 a_63_n131#
X0 a_63_n131# G S1 B sky130_fd_pr__nfet_01v8 ad=0.31 pd=2.62 as=0.165 ps=1.33 w=1 l=0.15
X1 S1 G D0 B sky130_fd_pr__nfet_01v8 ad=0.165 pd=1.33 as=0.31 ps=2.62 w=1 l=0.15
C0 a_63_n131# S1 0.14954f
C1 G D0 0.02912f
C2 S1 D0 0.14954f
C3 G S1 0.05824f
C4 a_63_n131# G 0.02912f
C5 S1 B 0.02855f
C6 D0 B 0.13295f
C7 G B 0.43048f
C8 a_63_n131# B 0.13295f
.ends

.subckt comp_p VDD VSS BIAS_P VOUT VIN_P VIN_N
Xsky130_fd_pr__pfet_01v8_UFRNYY_1 VDD sky130_fd_pr__pfet_01v8_UFRNYY_1/D sky130_fd_pr__pfet_01v8_UFRNYY_1/S
+ sky130_fd_pr__pfet_01v8_UFRNYY_1/S VSS sky130_fd_pr__pfet_01v8_UFRNYY
Xsky130_fd_pr__nfet_01v8_CTHBRU_0 VSS sky130_fd_pr__pfet_01v8_UFRNYY_1/S VSS sky130_fd_pr__nfet_01v8_CTHBRU_0/G
+ sky130_fd_pr__nfet_01v8_CTHBRU
Xsky130_fd_pr__nfet_01v8_CTHBRU_1 VSS VSS VOUT sky130_fd_pr__nfet_01v8_CTHBRU_1/G
+ sky130_fd_pr__nfet_01v8_CTHBRU
Xsky130_fd_pr__pfet_01v8_57LR5P_0 VDD VDD VDD VDD BIAS_P sky130_fd_pr__pfet_01v8_57LR5P_0/D6
+ BIAS_P VDD BIAS_P sky130_fd_pr__pfet_01v8_57LR5P_0/D6 BIAS_P VDD BIAS_P sky130_fd_pr__pfet_01v8_57LR5P_0/D6
+ VDD VDD VSS sky130_fd_pr__pfet_01v8_57LR5P
Xsky130_fd_pr__pfet_01v8_FTRNYQ_0 VDD sky130_fd_pr__pfet_01v8_UFRNYY_1/D VDD sky130_fd_pr__pfet_01v8_UFRNYY_1/D
+ VSS sky130_fd_pr__pfet_01v8_FTRNYQ
Xsky130_fd_pr__pfet_01v8_4RRFEZ_0 VDD VDD VDD sky130_fd_pr__nfet_01v8_CTHBRU_1/G VIN_P
+ sky130_fd_pr__pfet_01v8_57LR5P_0/D6 VIN_N sky130_fd_pr__nfet_01v8_CTHBRU_0/G VIN_N
+ sky130_fd_pr__pfet_01v8_57LR5P_0/D6 VIN_P sky130_fd_pr__nfet_01v8_CTHBRU_1/G VDD
+ VDD VSS sky130_fd_pr__pfet_01v8_4RRFEZ
Xsky130_fd_pr__nfet_01v8_9DM3XL_0 VSS sky130_fd_pr__nfet_01v8_CTHBRU_0/G sky130_fd_pr__nfet_01v8_CTHBRU_0/G
+ VSS sky130_fd_pr__nfet_01v8_CTHBRU_1/G sky130_fd_pr__nfet_01v8_9DM3XL
Xsky130_fd_pr__nfet_01v8_9DM3XL_1 VSS sky130_fd_pr__nfet_01v8_CTHBRU_0/G sky130_fd_pr__nfet_01v8_CTHBRU_1/G
+ VSS sky130_fd_pr__nfet_01v8_CTHBRU_1/G sky130_fd_pr__nfet_01v8_9DM3XL
Xsky130_fd_pr__pfet_01v8_UFRNYY_0 VDD VDD VOUT sky130_fd_pr__pfet_01v8_UFRNYY_1/D
+ VSS sky130_fd_pr__pfet_01v8_UFRNYY
C0 sky130_fd_pr__nfet_01v8_CTHBRU_0/G VIN_N 0.15231f
C1 sky130_fd_pr__nfet_01v8_CTHBRU_1/G VIN_N 0.07339f
C2 BIAS_P sky130_fd_pr__nfet_01v8_CTHBRU_0/G 0.01824f
C3 BIAS_P sky130_fd_pr__nfet_01v8_CTHBRU_1/G 0.04309f
C4 VIN_P sky130_fd_pr__pfet_01v8_UFRNYY_1/S 0.00467f
C5 VDD sky130_fd_pr__pfet_01v8_UFRNYY_1/D 0.71345f
C6 VDD sky130_fd_pr__pfet_01v8_UFRNYY_1/S 0.26325f
C7 sky130_fd_pr__pfet_01v8_57LR5P_0/D6 sky130_fd_pr__pfet_01v8_UFRNYY_1/D 0.0284f
C8 sky130_fd_pr__pfet_01v8_57LR5P_0/D6 sky130_fd_pr__pfet_01v8_UFRNYY_1/S 0
C9 sky130_fd_pr__nfet_01v8_CTHBRU_0/G VIN_P 0.33004f
C10 VIN_P sky130_fd_pr__nfet_01v8_CTHBRU_1/G 0.22986f
C11 sky130_fd_pr__nfet_01v8_CTHBRU_0/G VDD 0.15675f
C12 VDD sky130_fd_pr__nfet_01v8_CTHBRU_1/G 0.44075f
C13 sky130_fd_pr__nfet_01v8_CTHBRU_0/G sky130_fd_pr__pfet_01v8_57LR5P_0/D6 0.0279f
C14 sky130_fd_pr__pfet_01v8_57LR5P_0/D6 sky130_fd_pr__nfet_01v8_CTHBRU_1/G 0.29197f
C15 VOUT sky130_fd_pr__pfet_01v8_UFRNYY_1/D 0.13913f
C16 BIAS_P VIN_N 0.01051f
C17 VOUT sky130_fd_pr__pfet_01v8_UFRNYY_1/S 0.14391f
C18 VOUT sky130_fd_pr__nfet_01v8_CTHBRU_0/G 0.00687f
C19 VOUT sky130_fd_pr__nfet_01v8_CTHBRU_1/G 0.05882f
C20 VIN_P VIN_N 0.57969f
C21 BIAS_P VIN_P 0.01146f
C22 VDD VIN_N 0.29982f
C23 BIAS_P VDD 0.82548f
C24 sky130_fd_pr__pfet_01v8_UFRNYY_1/S sky130_fd_pr__pfet_01v8_UFRNYY_1/D 0.09636f
C25 sky130_fd_pr__pfet_01v8_57LR5P_0/D6 VIN_N 0.055f
C26 BIAS_P sky130_fd_pr__pfet_01v8_57LR5P_0/D6 0.47361f
C27 sky130_fd_pr__nfet_01v8_CTHBRU_1/G sky130_fd_pr__pfet_01v8_UFRNYY_1/D 0.02929f
C28 sky130_fd_pr__nfet_01v8_CTHBRU_0/G sky130_fd_pr__pfet_01v8_UFRNYY_1/S 0.22631f
C29 sky130_fd_pr__pfet_01v8_UFRNYY_1/S sky130_fd_pr__nfet_01v8_CTHBRU_1/G 0.0908f
C30 VIN_P VDD 0.13469f
C31 VIN_P sky130_fd_pr__pfet_01v8_57LR5P_0/D6 0.04934f
C32 sky130_fd_pr__nfet_01v8_CTHBRU_0/G sky130_fd_pr__nfet_01v8_CTHBRU_1/G 0.61185f
C33 VDD sky130_fd_pr__pfet_01v8_57LR5P_0/D6 0.53432f
C34 VOUT VIN_P 0
C35 VOUT VDD 0.29034f
C36 BIAS_P sky130_fd_pr__pfet_01v8_UFRNYY_1/D 0
C37 sky130_fd_pr__pfet_01v8_UFRNYY_1/S VIN_N 0.00415f
C38 VDD VSS 14.52841f
C39 VOUT VSS 0.45519f
C40 sky130_fd_pr__nfet_01v8_CTHBRU_0/G VSS 1.68429f
C41 sky130_fd_pr__nfet_01v8_CTHBRU_1/G VSS 1.55563f
C42 VIN_N VSS 0.18058f
C43 VIN_P VSS 0.50258f
C44 sky130_fd_pr__pfet_01v8_57LR5P_0/D6 VSS 0.27415f
C45 BIAS_P VSS 0.6074f
C46 sky130_fd_pr__pfet_01v8_UFRNYY_1/D VSS 0.12555f
C47 sky130_fd_pr__pfet_01v8_UFRNYY_1/S VSS 0.58083f
.ends

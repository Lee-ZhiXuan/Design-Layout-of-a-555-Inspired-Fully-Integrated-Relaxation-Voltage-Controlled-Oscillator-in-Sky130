* SPICE3 file created from ptat_test.ext - technology: sky130A

.subckt sky130_fd_pr__nfet_01v8_KXES5E D0 G S1 a_129_n169# VSUBS
X0 a_129_n169# G S1 VSUBS sky130_fd_pr__nfet_01v8 ad=0.58 pd=4.58 as=0.29 ps=2.29 w=2 l=0.5
X1 S1 G D0 VSUBS sky130_fd_pr__nfet_01v8 ad=0.29 pd=2.29 as=0.58 ps=4.58 w=2 l=0.5
C0 D0 G 0.05026f
C1 G a_129_n169# 0.05026f
C2 D0 S1 0.17948f
C3 a_129_n169# S1 0.17948f
C4 G S1 0.10052f
C5 S1 VSUBS 0.04825f
C6 D0 VSUBS 0.20369f
C7 G VSUBS 0.58972f
C8 a_129_n169# VSUBS 0.20369f
.ends

.subckt sky130_fd_pr__nfet_01v8_44FS3R B D0 G S1 a_179_n281#
X0 S1 G D0 B sky130_fd_pr__nfet_01v8 ad=0.3625 pd=2.79 as=0.725 ps=5.58 w=2.5 l=0.75
X1 a_179_n281# G S1 B sky130_fd_pr__nfet_01v8 ad=0.725 pd=5.58 as=0.3625 ps=2.79 w=2.5 l=0.75
C0 G a_179_n281# 0.07f
C1 D0 S1 0.17037f
C2 G S1 0.14f
C3 G D0 0.07f
C4 a_179_n281# S1 0.17037f
C5 S1 B 0.07399f
C6 D0 B 0.3023f
C7 G B 0.85441f
C8 a_179_n281# B 0.3023f
.ends

.subckt sky130_fd_pr__res_xhigh_po_0p35_S4LC8G R1 R2 VSUBS
X0 R1 R2 VSUBS sky130_fd_pr__res_xhigh_po_0p35 l=2.65
C0 R1 R2 0.00737f
C1 R2 VSUBS 0.58514f
C2 R1 VSUBS 0.58514f
.ends

.subckt sky130_fd_pr__nfet_01v8_SWJJUK D0 G S1 a_129_n231# VSUBS
X0 S1 G D0 VSUBS sky130_fd_pr__nfet_01v8 ad=0.29 pd=2.29 as=0.58 ps=4.58 w=2 l=0.5
X1 a_129_n231# G S1 VSUBS sky130_fd_pr__nfet_01v8 ad=0.58 pd=4.58 as=0.29 ps=2.29 w=2 l=0.5
C0 D0 S1 0.17948f
C1 G a_129_n231# 0.05026f
C2 G S1 0.10052f
C3 G D0 0.05026f
C4 a_129_n231# S1 0.17948f
C5 S1 VSUBS 0.04825f
C6 D0 VSUBS 0.20369f
C7 G VSUBS 0.58972f
C8 a_129_n231# VSUBS 0.20369f
.ends

.subckt sky130_fd_pr__pfet_01v8_3CTS57_mod1 D0 G S1 a_129_n236# w_n223_n298# VSUBS
X0 a_129_n236# G S1 w_n223_n298# sky130_fd_pr__pfet_01v8 ad=0.58 pd=4.58 as=0.29 ps=2.29 w=2 l=0.5
X1 S1 G D0 w_n223_n298# sky130_fd_pr__pfet_01v8 ad=0.29 pd=2.29 as=0.58 ps=4.58 w=2 l=0.5
C0 a_129_n236# S1 0.17948f
C1 G D0 0.02964f
C2 S1 w_n223_n298# 0.00361f
C3 a_129_n236# w_n223_n298# 0.01048f
C4 S1 D0 0.17948f
C5 S1 G 0.09632f
C6 a_129_n236# G 0.02964f
C7 w_n223_n298# D0 0.01048f
C8 w_n223_n298# G 0.15044f
C9 S1 VSUBS 0.04491f
C10 D0 VSUBS 0.20076f
C11 G VSUBS 0.42604f
C12 a_129_n236# VSUBS 0.20076f
C13 w_n223_n298# VSUBS 0.75196f
.ends

.subckt sky130_fd_pr__pfet_01v8_LBPW5X_mod1 D0 G S1 w_n223_n264# a_129_n164# VSUBS
X0 a_129_n164# G S1 w_n223_n264# sky130_fd_pr__pfet_01v8 ad=0.58 pd=4.58 as=0.29 ps=2.29 w=2 l=0.5
X1 S1 G D0 w_n223_n264# sky130_fd_pr__pfet_01v8 ad=0.29 pd=2.29 as=0.58 ps=4.58 w=2 l=0.5
C0 a_129_n164# S1 0.17948f
C1 G D0 0.02964f
C2 S1 w_n223_n264# 0.00361f
C3 a_129_n164# w_n223_n264# 0.01048f
C4 S1 D0 0.17948f
C5 S1 G 0.09632f
C6 a_129_n164# G 0.02964f
C7 w_n223_n264# D0 0.01048f
C8 w_n223_n264# G 0.15044f
C9 S1 VSUBS 0.04491f
C10 D0 VSUBS 0.20076f
C11 G VSUBS 0.42604f
C12 a_129_n164# VSUBS 0.20076f
C13 w_n223_n264# VSUBS 0.75196f
.ends

.subckt sky130_fd_pr__pfet_01v8_YRZA2J B D S G VSUBS
X0 S G D B sky130_fd_pr__pfet_01v8 ad=0.29 pd=2.58 as=0.29 ps=2.58 w=1 l=10
C0 G B 2.29742f
C1 G S 0.04934f
C2 G D 0.04934f
C3 B S 0.08756f
C4 B D 0.08756f
C5 S VSUBS 0.09221f
C6 D VSUBS 0.09221f
C7 G VSUBS 2.34446f
C8 B VSUBS 5.56715f
.ends

.subckt sky130_fd_pr__pfet_01v8_57LS5R B D0 G S1 D2 S3 D4 S4 VSUBS
X0 S3 G D2 B sky130_fd_pr__pfet_01v8 ad=0.29 pd=2.29 as=0.29 ps=2.29 w=2 l=0.75
X1 S4 G D4 B sky130_fd_pr__pfet_01v8 ad=0.58 pd=4.58 as=0.29 ps=2.29 w=2 l=0.75
X2 D4 G S3 B sky130_fd_pr__pfet_01v8 ad=0.29 pd=2.29 as=0.29 ps=2.29 w=2 l=0.75
X3 S1 G D0 B sky130_fd_pr__pfet_01v8 ad=0.29 pd=2.29 as=0.58 ps=4.58 w=2 l=0.75
X4 D2 G S1 B sky130_fd_pr__pfet_01v8 ad=0.29 pd=2.29 as=0.29 ps=2.29 w=2 l=0.75
C0 G S4 0.05902f
C1 G D2 0.11803f
C2 D0 S1 0.13656f
C3 B S4 0.14402f
C4 D4 S4 0.13656f
C5 D2 B 0.01465f
C6 D2 S3 0.13656f
C7 G B 1.11891f
C8 G S3 0.11803f
C9 G D4 0.11803f
C10 D2 S1 0.13656f
C11 G S1 0.11803f
C12 B S3 0.01465f
C13 G D0 0.05902f
C14 D4 B 0.01465f
C15 D4 S3 0.13656f
C16 B S1 0.01465f
C17 B D0 0.14402f
C18 S4 VSUBS 0.10392f
C19 D4 VSUBS 0.0486f
C20 S3 VSUBS 0.0486f
C21 D2 VSUBS 0.0486f
C22 S1 VSUBS 0.0486f
C23 D0 VSUBS 0.10392f
C24 G VSUBS 0.93282f
C25 B VSUBS 4.1935f
.ends

.subckt sky130_fd_pr__pfet_01v8_3CBY59 D S G w_n144_n298# VSUBS
X0 S G D w_n144_n298# sky130_fd_pr__pfet_01v8 ad=0.58 pd=4.58 as=0.58 ps=4.58 w=2 l=0.5
C0 w_n144_n298# G 0.08002f
C1 D S 0.17948f
C2 D G 0.02866f
C3 D w_n144_n298# 0.01048f
C4 S G 0.02866f
C5 S w_n144_n298# 0.01048f
C6 S VSUBS 0.20076f
C7 D VSUBS 0.20076f
C8 G VSUBS 0.22612f
C9 w_n144_n298# VSUBS 0.48557f
.ends

.subckt sky130_fd_pr__pfet_01v8_PB76X2 D S G w_n144_n264# VSUBS
X0 S G D w_n144_n264# sky130_fd_pr__pfet_01v8 ad=0.58 pd=4.58 as=0.58 ps=4.58 w=2 l=0.5
C0 w_n144_n264# G 0.08002f
C1 D S 0.17948f
C2 D G 0.02866f
C3 D w_n144_n264# 0.01048f
C4 S G 0.02866f
C5 S w_n144_n264# 0.01048f
C6 S VSUBS 0.20076f
C7 D VSUBS 0.20076f
C8 G VSUBS 0.22612f
C9 w_n144_n264# VSUBS 0.48557f
.ends

.subckt sky130_fd_pr__nfet_01v8_FBEKU3 D0 G S1 D2 S3 a_287_n231# VSUBS
X0 D2 G S1 VSUBS sky130_fd_pr__nfet_01v8 ad=0.29 pd=2.29 as=0.29 ps=2.29 w=2 l=0.5
X1 S1 G D0 VSUBS sky130_fd_pr__nfet_01v8 ad=0.29 pd=2.29 as=0.58 ps=4.58 w=2 l=0.5
X2 a_287_n231# G S3 VSUBS sky130_fd_pr__nfet_01v8 ad=0.58 pd=4.58 as=0.29 ps=2.29 w=2 l=0.5
X3 S3 G D2 VSUBS sky130_fd_pr__nfet_01v8 ad=0.29 pd=2.29 as=0.29 ps=2.29 w=2 l=0.5
C0 D2 G 0.10052f
C1 a_287_n231# G 0.05026f
C2 D2 S3 0.17948f
C3 D0 S1 0.17948f
C4 S3 G 0.10052f
C5 S3 a_287_n231# 0.17948f
C6 D0 G 0.05026f
C7 D2 S1 0.17948f
C8 S1 G 0.10052f
C9 S3 VSUBS 0.04825f
C10 D2 VSUBS 0.04825f
C11 S1 VSUBS 0.04825f
C12 D0 VSUBS 0.20369f
C13 G VSUBS 1.10656f
C14 a_287_n231# VSUBS 0.20369f
.ends

.subckt sky130_fd_pr__nfet_01v8_B6AF5W D0 G S1 D2 S3 a_287_n169# VSUBS
X0 S3 G D2 VSUBS sky130_fd_pr__nfet_01v8 ad=0.29 pd=2.29 as=0.29 ps=2.29 w=2 l=0.5
X1 D2 G S1 VSUBS sky130_fd_pr__nfet_01v8 ad=0.29 pd=2.29 as=0.29 ps=2.29 w=2 l=0.5
X2 S1 G D0 VSUBS sky130_fd_pr__nfet_01v8 ad=0.29 pd=2.29 as=0.58 ps=4.58 w=2 l=0.5
X3 a_287_n169# G S3 VSUBS sky130_fd_pr__nfet_01v8 ad=0.58 pd=4.58 as=0.29 ps=2.29 w=2 l=0.5
C0 D2 G 0.10052f
C1 a_287_n169# G 0.05026f
C2 D2 S3 0.17948f
C3 D0 S1 0.17948f
C4 S3 G 0.10052f
C5 S3 a_287_n169# 0.17948f
C6 D0 G 0.05026f
C7 D2 S1 0.17948f
C8 S1 G 0.10052f
C9 S3 VSUBS 0.04825f
C10 D2 VSUBS 0.04825f
C11 S1 VSUBS 0.04825f
C12 D0 VSUBS 0.20369f
C13 G VSUBS 1.10656f
C14 a_287_n169# VSUBS 0.20369f
.ends

.subckt ptat_test VDD VSS BIAS_P BIAS_N
Xsky130_fd_pr__nfet_01v8_KXES5E_4 VSS VSS VSS VSS VSS sky130_fd_pr__nfet_01v8_KXES5E
Xsky130_fd_pr__nfet_01v8_44FS3R_0 VSS VSS BIAS_N BIAS_N VSS sky130_fd_pr__nfet_01v8_44FS3R
Xsky130_fd_pr__res_xhigh_po_0p35_S4LC8G_0 sky130_fd_pr__nfet_01v8_SWJJUK_2/S1 VSS
+ VSS sky130_fd_pr__res_xhigh_po_0p35_S4LC8G
Xsky130_fd_pr__nfet_01v8_SWJJUK_0 VSS VSS VSS VSS VSS sky130_fd_pr__nfet_01v8_SWJJUK
Xsky130_fd_pr__nfet_01v8_SWJJUK_2 sky130_fd_pr__nfet_01v8_SWJJUK_2/D0 sky130_fd_pr__pfet_01v8_YRZA2J_0/S
+ sky130_fd_pr__nfet_01v8_SWJJUK_2/S1 sky130_fd_pr__nfet_01v8_SWJJUK_2/D0 VSS sky130_fd_pr__nfet_01v8_SWJJUK
Xsky130_fd_pr__nfet_01v8_SWJJUK_4 VSS VSS VSS VSS VSS sky130_fd_pr__nfet_01v8_SWJJUK
Xsky130_fd_pr__pfet_01v8_3CTS57_mod1_0 sky130_fd_pr__pfet_01v8_LBPW5X_mod1_0/D0 BIAS_P
+ VDD sky130_fd_pr__pfet_01v8_LBPW5X_mod1_0/D0 VDD VSS sky130_fd_pr__pfet_01v8_3CTS57_mod1
Xsky130_fd_pr__pfet_01v8_LBPW5X_mod1_0 sky130_fd_pr__pfet_01v8_LBPW5X_mod1_0/D0 BIAS_P
+ BIAS_P VDD sky130_fd_pr__pfet_01v8_LBPW5X_mod1_0/D0 VSS sky130_fd_pr__pfet_01v8_LBPW5X_mod1
Xsky130_fd_pr__pfet_01v8_YRZA2J_0 VDD VDD sky130_fd_pr__pfet_01v8_YRZA2J_0/S VSS VSS
+ sky130_fd_pr__pfet_01v8_YRZA2J
Xsky130_fd_pr__pfet_01v8_57LS5R_0 VDD VDD BIAS_P BIAS_N VDD BIAS_N VDD BIAS_N VSS
+ sky130_fd_pr__pfet_01v8_57LS5R
Xsky130_fd_pr__pfet_01v8_3CBY59_0 sky130_fd_pr__pfet_01v8_PB76X2_2/S sky130_fd_pr__pfet_01v8_YRZA2J_0/S
+ BIAS_P VDD VSS sky130_fd_pr__pfet_01v8_3CBY59
Xsky130_fd_pr__pfet_01v8_3CBY59_1 VDD VDD VDD VDD VSS sky130_fd_pr__pfet_01v8_3CBY59
Xsky130_fd_pr__pfet_01v8_PB76X2_0 sky130_fd_pr__pfet_01v8_PB76X2_2/S VDD BIAS_P VDD
+ VSS sky130_fd_pr__pfet_01v8_PB76X2
Xsky130_fd_pr__pfet_01v8_3CBY59_2 sky130_fd_pr__pfet_01v8_YRZA2J_0/S sky130_fd_pr__pfet_01v8_PB76X2_2/S
+ BIAS_P VDD VSS sky130_fd_pr__pfet_01v8_3CBY59
Xsky130_fd_pr__pfet_01v8_PB76X2_1 VDD VDD VDD VDD VSS sky130_fd_pr__pfet_01v8_PB76X2
Xsky130_fd_pr__pfet_01v8_3CBY59_3 VDD VDD VDD VDD VSS sky130_fd_pr__pfet_01v8_3CBY59
Xsky130_fd_pr__pfet_01v8_PB76X2_2 VDD sky130_fd_pr__pfet_01v8_PB76X2_2/S BIAS_P VDD
+ VSS sky130_fd_pr__pfet_01v8_PB76X2
Xsky130_fd_pr__pfet_01v8_PB76X2_3 VDD VDD VDD VDD VSS sky130_fd_pr__pfet_01v8_PB76X2
Xsky130_fd_pr__nfet_01v8_KXES5E_0 VSS VSS VSS VSS VSS sky130_fd_pr__nfet_01v8_KXES5E
Xsky130_fd_pr__nfet_01v8_FBEKU3_0 sky130_fd_pr__nfet_01v8_FBEKU3_0/D2 sky130_fd_pr__pfet_01v8_YRZA2J_0/S
+ sky130_fd_pr__pfet_01v8_YRZA2J_0/S sky130_fd_pr__nfet_01v8_FBEKU3_0/D2 sky130_fd_pr__pfet_01v8_YRZA2J_0/S
+ sky130_fd_pr__nfet_01v8_FBEKU3_0/D2 VSS sky130_fd_pr__nfet_01v8_FBEKU3
Xsky130_fd_pr__nfet_01v8_B6AF5W_0 sky130_fd_pr__nfet_01v8_FBEKU3_0/D2 sky130_fd_pr__pfet_01v8_YRZA2J_0/S
+ VSS sky130_fd_pr__nfet_01v8_FBEKU3_0/D2 VSS sky130_fd_pr__nfet_01v8_FBEKU3_0/D2
+ VSS sky130_fd_pr__nfet_01v8_B6AF5W
Xsky130_fd_pr__nfet_01v8_KXES5E_2 sky130_fd_pr__nfet_01v8_SWJJUK_2/D0 sky130_fd_pr__pfet_01v8_YRZA2J_0/S
+ BIAS_P sky130_fd_pr__nfet_01v8_SWJJUK_2/D0 VSS sky130_fd_pr__nfet_01v8_KXES5E
C0 BIAS_N VDD 0.35659f
C1 sky130_fd_pr__nfet_01v8_SWJJUK_2/D0 VSS 0.54784f
C2 sky130_fd_pr__nfet_01v8_SWJJUK_2/S1 VDD 0.00997f
C3 sky130_fd_pr__pfet_01v8_PB76X2_2/S sky130_fd_pr__nfet_01v8_FBEKU3_0/D2 0.00127f
C4 BIAS_P sky130_fd_pr__pfet_01v8_YRZA2J_0/S 0.19313f
C5 sky130_fd_pr__nfet_01v8_SWJJUK_2/D0 sky130_fd_pr__pfet_01v8_YRZA2J_0/S 0.56945f
C6 BIAS_N sky130_fd_pr__nfet_01v8_SWJJUK_2/S1 0.11155f
C7 sky130_fd_pr__pfet_01v8_PB76X2_2/S VSS 0.00118f
C8 sky130_fd_pr__pfet_01v8_PB76X2_2/S sky130_fd_pr__pfet_01v8_YRZA2J_0/S 0.02938f
C9 sky130_fd_pr__nfet_01v8_SWJJUK_2/D0 BIAS_P 0.04672f
C10 sky130_fd_pr__pfet_01v8_LBPW5X_mod1_0/D0 sky130_fd_pr__nfet_01v8_FBEKU3_0/D2 0.02413f
C11 VDD sky130_fd_pr__nfet_01v8_FBEKU3_0/D2 0.0167f
C12 sky130_fd_pr__pfet_01v8_LBPW5X_mod1_0/D0 VSS 0.00107f
C13 sky130_fd_pr__pfet_01v8_PB76X2_2/S BIAS_P 1.1862f
C14 VSS VDD 0.50662f
C15 BIAS_N sky130_fd_pr__nfet_01v8_FBEKU3_0/D2 0
C16 sky130_fd_pr__nfet_01v8_SWJJUK_2/S1 sky130_fd_pr__nfet_01v8_FBEKU3_0/D2 0.00818f
C17 sky130_fd_pr__pfet_01v8_LBPW5X_mod1_0/D0 sky130_fd_pr__pfet_01v8_YRZA2J_0/S 0.55885f
C18 VDD sky130_fd_pr__pfet_01v8_YRZA2J_0/S 0.94897f
C19 VSS BIAS_N 0.0979f
C20 VSS sky130_fd_pr__nfet_01v8_SWJJUK_2/S1 0.36312f
C21 BIAS_N sky130_fd_pr__pfet_01v8_YRZA2J_0/S 0
C22 sky130_fd_pr__nfet_01v8_SWJJUK_2/S1 sky130_fd_pr__pfet_01v8_YRZA2J_0/S 0.09814f
C23 sky130_fd_pr__pfet_01v8_LBPW5X_mod1_0/D0 BIAS_P 0.48384f
C24 VDD BIAS_P 1.85162f
C25 sky130_fd_pr__nfet_01v8_SWJJUK_2/D0 VDD 0.0177f
C26 BIAS_N BIAS_P 0.68746f
C27 sky130_fd_pr__nfet_01v8_SWJJUK_2/S1 BIAS_P 0.04498f
C28 sky130_fd_pr__pfet_01v8_PB76X2_2/S sky130_fd_pr__pfet_01v8_LBPW5X_mod1_0/D0 0.0691f
C29 sky130_fd_pr__nfet_01v8_SWJJUK_2/D0 BIAS_N 0.00246f
C30 VSS sky130_fd_pr__nfet_01v8_FBEKU3_0/D2 0.55416f
C31 sky130_fd_pr__pfet_01v8_PB76X2_2/S VDD 1.40026f
C32 sky130_fd_pr__nfet_01v8_SWJJUK_2/D0 sky130_fd_pr__nfet_01v8_SWJJUK_2/S1 0.05708f
C33 sky130_fd_pr__nfet_01v8_FBEKU3_0/D2 sky130_fd_pr__pfet_01v8_YRZA2J_0/S 0.74637f
C34 sky130_fd_pr__pfet_01v8_PB76X2_2/S BIAS_N 0
C35 VSS sky130_fd_pr__pfet_01v8_YRZA2J_0/S 0.65887f
C36 sky130_fd_pr__pfet_01v8_LBPW5X_mod1_0/D0 VDD 0.96512f
C37 sky130_fd_pr__nfet_01v8_FBEKU3_0/D2 BIAS_P 0.02761f
C38 sky130_fd_pr__nfet_01v8_SWJJUK_2/D0 sky130_fd_pr__nfet_01v8_FBEKU3_0/D2 0.31561f
C39 VSS BIAS_P 0.05674f
C40 sky130_fd_pr__pfet_01v8_LBPW5X_mod1_0/D0 BIAS_N 0.00422f
C41 BIAS_P 0 2.32011f
C42 sky130_fd_pr__nfet_01v8_SWJJUK_2/D0 0 0.33707f
C43 sky130_fd_pr__nfet_01v8_FBEKU3_0/D2 0 1.19012f
C44 VSS 0 2.85815f
C45 VDD 0 20.60588f
C46 sky130_fd_pr__pfet_01v8_YRZA2J_0/S 0 3.58808f
C47 sky130_fd_pr__pfet_01v8_PB76X2_2/S 0 0.10064f
C48 sky130_fd_pr__pfet_01v8_LBPW5X_mod1_0/D0 0 0.18164f
C49 sky130_fd_pr__nfet_01v8_SWJJUK_2/S1 0 1.21604f
C50 BIAS_N 0 1.89943f
.ends

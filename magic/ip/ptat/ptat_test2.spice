* SPICE3 file created from ptat_test2.ext - technology: sky130A

.subckt sky130_fd_pr__nfet_01v8_KXES5E D0 G S1 a_129_n169# VSUBS
X0 a_129_n169# G S1 VSUBS sky130_fd_pr__nfet_01v8 ad=0.58 pd=4.58 as=0.29 ps=2.29 w=2 l=0.5
X1 S1 G D0 VSUBS sky130_fd_pr__nfet_01v8 ad=0.29 pd=2.29 as=0.58 ps=4.58 w=2 l=0.5
C0 G S1 0.10052f
C1 a_129_n169# S1 0.17948f
C2 a_129_n169# G 0.05026f
C3 D0 S1 0.17948f
C4 G D0 0.05026f
C5 S1 VSUBS 0.04825f
C6 D0 VSUBS 0.20369f
C7 G VSUBS 0.58972f
C8 a_129_n169# VSUBS 0.20369f
.ends

.subckt sky130_fd_pr__nfet_01v8_44FS3R B D0 G S1 a_179_n281#
X0 S1 G D0 B sky130_fd_pr__nfet_01v8 ad=0.3625 pd=2.79 as=0.725 ps=5.58 w=2.5 l=0.75
X1 a_179_n281# G S1 B sky130_fd_pr__nfet_01v8 ad=0.725 pd=5.58 as=0.3625 ps=2.79 w=2.5 l=0.75
C0 G a_179_n281# 0.07f
C1 D0 G 0.07f
C2 S1 a_179_n281# 0.17037f
C3 D0 S1 0.17037f
C4 S1 G 0.14f
C5 S1 B 0.07399f
C6 D0 B 0.3023f
C7 G B 0.85441f
C8 a_179_n281# B 0.3023f
.ends

.subckt sky130_fd_pr__res_xhigh_po_0p35_S4LC8G R1 R2 VSUBS
X0 R1 R2 VSUBS sky130_fd_pr__res_xhigh_po_0p35 l=2.65
C0 R2 R1 0.00737f
C1 R2 VSUBS 0.58514f
C2 R1 VSUBS 0.58514f
.ends

.subckt sky130_fd_pr__nfet_01v8_SWJJUK D0 G S1 a_129_n231# VSUBS
X0 S1 G D0 VSUBS sky130_fd_pr__nfet_01v8 ad=0.29 pd=2.29 as=0.58 ps=4.58 w=2 l=0.5
X1 a_129_n231# G S1 VSUBS sky130_fd_pr__nfet_01v8 ad=0.58 pd=4.58 as=0.29 ps=2.29 w=2 l=0.5
C0 S1 a_129_n231# 0.17948f
C1 D0 G 0.05026f
C2 D0 S1 0.17948f
C3 S1 G 0.10052f
C4 G a_129_n231# 0.05026f
C5 S1 VSUBS 0.04825f
C6 D0 VSUBS 0.20369f
C7 G VSUBS 0.58972f
C8 a_129_n231# VSUBS 0.20369f
.ends

.subckt sky130_fd_pr__pfet_01v8_3CTS57_mod1 D0 G S1 a_129_n236# w_n223_n298# VSUBS
X0 a_129_n236# G S1 w_n223_n298# sky130_fd_pr__pfet_01v8 ad=0.58 pd=4.58 as=0.29 ps=2.29 w=2 l=0.5
X1 S1 G D0 w_n223_n298# sky130_fd_pr__pfet_01v8 ad=0.29 pd=2.29 as=0.58 ps=4.58 w=2 l=0.5
C0 D0 w_n223_n298# 0.01048f
C1 G a_129_n236# 0.02964f
C2 G S1 0.09632f
C3 G D0 0.02964f
C4 S1 a_129_n236# 0.17948f
C5 G w_n223_n298# 0.15044f
C6 S1 D0 0.17948f
C7 a_129_n236# w_n223_n298# 0.01048f
C8 S1 w_n223_n298# 0.00361f
C9 S1 VSUBS 0.04491f
C10 D0 VSUBS 0.20076f
C11 G VSUBS 0.42604f
C12 a_129_n236# VSUBS 0.20076f
C13 w_n223_n298# VSUBS 0.75196f
.ends

.subckt sky130_fd_pr__pfet_01v8_LBPW5X_mod1 D0 G S1 w_n223_n264# a_129_n164# VSUBS
X0 a_129_n164# G S1 w_n223_n264# sky130_fd_pr__pfet_01v8 ad=0.58 pd=4.58 as=0.29 ps=2.29 w=2 l=0.5
X1 S1 G D0 w_n223_n264# sky130_fd_pr__pfet_01v8 ad=0.29 pd=2.29 as=0.58 ps=4.58 w=2 l=0.5
C0 D0 w_n223_n264# 0.01048f
C1 G a_129_n164# 0.02964f
C2 G S1 0.09632f
C3 G D0 0.02964f
C4 S1 a_129_n164# 0.17948f
C5 G w_n223_n264# 0.15044f
C6 S1 D0 0.17948f
C7 a_129_n164# w_n223_n264# 0.01048f
C8 S1 w_n223_n264# 0.00361f
C9 S1 VSUBS 0.04491f
C10 D0 VSUBS 0.20076f
C11 G VSUBS 0.42604f
C12 a_129_n164# VSUBS 0.20076f
C13 w_n223_n264# VSUBS 0.75196f
.ends

.subckt sky130_fd_pr__pfet_01v8_57LS5R B D0 G S1 D2 S3 D4 S4 VSUBS
X0 S3 G D2 B sky130_fd_pr__pfet_01v8 ad=0.29 pd=2.29 as=0.29 ps=2.29 w=2 l=0.75
X1 S4 G D4 B sky130_fd_pr__pfet_01v8 ad=0.58 pd=4.58 as=0.29 ps=2.29 w=2 l=0.75
X2 D4 G S3 B sky130_fd_pr__pfet_01v8 ad=0.29 pd=2.29 as=0.29 ps=2.29 w=2 l=0.75
X3 S1 G D0 B sky130_fd_pr__pfet_01v8 ad=0.29 pd=2.29 as=0.58 ps=4.58 w=2 l=0.75
X4 D2 G S1 B sky130_fd_pr__pfet_01v8 ad=0.29 pd=2.29 as=0.29 ps=2.29 w=2 l=0.75
C0 D4 G 0.11803f
C1 S3 B 0.01465f
C2 S1 B 0.01465f
C3 D4 S3 0.13656f
C4 S4 B 0.14402f
C5 D0 G 0.05902f
C6 S4 D4 0.13656f
C7 D4 B 0.01465f
C8 D0 S1 0.13656f
C9 D2 G 0.11803f
C10 D0 B 0.14402f
C11 S3 G 0.11803f
C12 D2 S3 0.13656f
C13 S1 G 0.11803f
C14 D2 S1 0.13656f
C15 S4 G 0.05902f
C16 G B 1.11891f
C17 D2 B 0.01465f
C18 S4 VSUBS 0.10392f
C19 D4 VSUBS 0.0486f
C20 S3 VSUBS 0.0486f
C21 D2 VSUBS 0.0486f
C22 S1 VSUBS 0.0486f
C23 D0 VSUBS 0.10392f
C24 G VSUBS 0.93282f
C25 B VSUBS 4.1935f
.ends

.subckt sky130_fd_pr__pfet_01v8_3CBY59 D S G w_n144_n298# VSUBS
X0 S G D w_n144_n298# sky130_fd_pr__pfet_01v8 ad=0.58 pd=4.58 as=0.58 ps=4.58 w=2 l=0.5
C0 w_n144_n298# D 0.01048f
C1 w_n144_n298# S 0.01048f
C2 w_n144_n298# G 0.08002f
C3 D S 0.17948f
C4 D G 0.02866f
C5 S G 0.02866f
C6 S VSUBS 0.20076f
C7 D VSUBS 0.20076f
C8 G VSUBS 0.22612f
C9 w_n144_n298# VSUBS 0.48557f
.ends

.subckt sky130_fd_pr__pfet_01v8_PB76X2 D S G w_n144_n264# VSUBS
X0 S G D w_n144_n264# sky130_fd_pr__pfet_01v8 ad=0.58 pd=4.58 as=0.58 ps=4.58 w=2 l=0.5
C0 w_n144_n264# D 0.01048f
C1 w_n144_n264# S 0.01048f
C2 w_n144_n264# G 0.08002f
C3 D S 0.17948f
C4 D G 0.02866f
C5 S G 0.02866f
C6 S VSUBS 0.20076f
C7 D VSUBS 0.20076f
C8 G VSUBS 0.22612f
C9 w_n144_n264# VSUBS 0.48557f
.ends

.subckt ptat_test2 VDD VSS BIAS_P BIAS_N
Xsky130_fd_pr__nfet_01v8_KXES5E_4 VSS VSS VSS VSS VSS sky130_fd_pr__nfet_01v8_KXES5E
Xsky130_fd_pr__nfet_01v8_44FS3R_0 VSS VSS BIAS_N BIAS_N VSS sky130_fd_pr__nfet_01v8_44FS3R
Xsky130_fd_pr__res_xhigh_po_0p35_S4LC8G_0 sky130_fd_pr__nfet_01v8_SWJJUK_2/S1 VSS
+ VSS sky130_fd_pr__res_xhigh_po_0p35_S4LC8G
Xsky130_fd_pr__nfet_01v8_SWJJUK_0 VSS VSS VSS VSS VSS sky130_fd_pr__nfet_01v8_SWJJUK
Xsky130_fd_pr__nfet_01v8_SWJJUK_2 sky130_fd_pr__nfet_01v8_SWJJUK_2/D0 sky130_fd_pr__pfet_01v8_3CBY59_2/D
+ sky130_fd_pr__nfet_01v8_SWJJUK_2/S1 sky130_fd_pr__nfet_01v8_SWJJUK_2/D0 VSS sky130_fd_pr__nfet_01v8_SWJJUK
Xsky130_fd_pr__nfet_01v8_SWJJUK_3 sky130_fd_pr__nfet_01v8_SWJJUK_3/D0 sky130_fd_pr__pfet_01v8_3CBY59_2/D
+ sky130_fd_pr__pfet_01v8_3CBY59_2/D sky130_fd_pr__nfet_01v8_SWJJUK_3/D0 VSS sky130_fd_pr__nfet_01v8_SWJJUK
Xsky130_fd_pr__nfet_01v8_SWJJUK_4 VSS VSS VSS VSS VSS sky130_fd_pr__nfet_01v8_SWJJUK
Xsky130_fd_pr__pfet_01v8_3CTS57_mod1_0 sky130_fd_pr__pfet_01v8_LBPW5X_mod1_0/D0 BIAS_P
+ VDD sky130_fd_pr__pfet_01v8_LBPW5X_mod1_0/D0 VDD VSS sky130_fd_pr__pfet_01v8_3CTS57_mod1
Xsky130_fd_pr__pfet_01v8_LBPW5X_mod1_0 sky130_fd_pr__pfet_01v8_LBPW5X_mod1_0/D0 BIAS_P
+ BIAS_P VDD sky130_fd_pr__pfet_01v8_LBPW5X_mod1_0/D0 VSS sky130_fd_pr__pfet_01v8_LBPW5X_mod1
Xsky130_fd_pr__pfet_01v8_57LS5R_0 VDD VDD BIAS_P BIAS_N VDD BIAS_N VDD BIAS_N VSS
+ sky130_fd_pr__pfet_01v8_57LS5R
Xsky130_fd_pr__pfet_01v8_3CBY59_0 sky130_fd_pr__pfet_01v8_PB76X2_2/S sky130_fd_pr__pfet_01v8_3CBY59_2/D
+ BIAS_P VDD VSS sky130_fd_pr__pfet_01v8_3CBY59
Xsky130_fd_pr__pfet_01v8_3CBY59_1 VDD VDD VDD VDD VSS sky130_fd_pr__pfet_01v8_3CBY59
Xsky130_fd_pr__pfet_01v8_PB76X2_0 sky130_fd_pr__pfet_01v8_PB76X2_2/S VDD BIAS_P VDD
+ VSS sky130_fd_pr__pfet_01v8_PB76X2
Xsky130_fd_pr__pfet_01v8_3CBY59_2 sky130_fd_pr__pfet_01v8_3CBY59_2/D sky130_fd_pr__pfet_01v8_PB76X2_2/S
+ BIAS_P VDD VSS sky130_fd_pr__pfet_01v8_3CBY59
Xsky130_fd_pr__pfet_01v8_PB76X2_1 VDD VDD VDD VDD VSS sky130_fd_pr__pfet_01v8_PB76X2
Xsky130_fd_pr__pfet_01v8_3CBY59_3 VDD VDD VDD VDD VSS sky130_fd_pr__pfet_01v8_3CBY59
Xsky130_fd_pr__pfet_01v8_PB76X2_2 VDD sky130_fd_pr__pfet_01v8_PB76X2_2/S BIAS_P VDD
+ VSS sky130_fd_pr__pfet_01v8_PB76X2
Xsky130_fd_pr__pfet_01v8_PB76X2_3 VDD VDD VDD VDD VSS sky130_fd_pr__pfet_01v8_PB76X2
Xsky130_fd_pr__nfet_01v8_KXES5E_0 VSS VSS VSS VSS VSS sky130_fd_pr__nfet_01v8_KXES5E
Xsky130_fd_pr__nfet_01v8_KXES5E_2 sky130_fd_pr__nfet_01v8_SWJJUK_2/D0 sky130_fd_pr__pfet_01v8_3CBY59_2/D
+ BIAS_P sky130_fd_pr__nfet_01v8_SWJJUK_2/D0 VSS sky130_fd_pr__nfet_01v8_KXES5E
Xsky130_fd_pr__nfet_01v8_KXES5E_3 sky130_fd_pr__nfet_01v8_SWJJUK_3/D0 sky130_fd_pr__pfet_01v8_3CBY59_2/D
+ VSS sky130_fd_pr__nfet_01v8_SWJJUK_3/D0 VSS sky130_fd_pr__nfet_01v8_KXES5E
C0 sky130_fd_pr__pfet_01v8_LBPW5X_mod1_0/D0 sky130_fd_pr__pfet_01v8_3CBY59_2/D 0.53827f
C1 sky130_fd_pr__nfet_01v8_SWJJUK_2/D0 VSS 0.15214f
C2 BIAS_P sky130_fd_pr__nfet_01v8_SWJJUK_2/D0 0.03409f
C3 sky130_fd_pr__nfet_01v8_SWJJUK_3/D0 sky130_fd_pr__pfet_01v8_LBPW5X_mod1_0/D0 0.02305f
C4 VDD sky130_fd_pr__nfet_01v8_SWJJUK_2/D0 0.00333f
C5 sky130_fd_pr__pfet_01v8_3CBY59_2/D BIAS_N 0
C6 sky130_fd_pr__nfet_01v8_SWJJUK_2/D0 sky130_fd_pr__pfet_01v8_PB76X2_2/S 0
C7 sky130_fd_pr__nfet_01v8_SWJJUK_3/D0 BIAS_N 0.00199f
C8 BIAS_P VSS 0.08196f
C9 BIAS_N sky130_fd_pr__nfet_01v8_SWJJUK_2/S1 0.10631f
C10 VDD VSS 0.0681f
C11 VDD BIAS_P 1.88206f
C12 VSS sky130_fd_pr__pfet_01v8_PB76X2_2/S 0.00836f
C13 sky130_fd_pr__pfet_01v8_LBPW5X_mod1_0/D0 sky130_fd_pr__nfet_01v8_SWJJUK_2/D0 0.00473f
C14 BIAS_P sky130_fd_pr__pfet_01v8_PB76X2_2/S 1.19226f
C15 VDD sky130_fd_pr__pfet_01v8_PB76X2_2/S 1.40073f
C16 sky130_fd_pr__nfet_01v8_SWJJUK_3/D0 sky130_fd_pr__pfet_01v8_3CBY59_2/D 0.7766f
C17 sky130_fd_pr__pfet_01v8_3CBY59_2/D sky130_fd_pr__nfet_01v8_SWJJUK_2/S1 0.13338f
C18 sky130_fd_pr__nfet_01v8_SWJJUK_3/D0 sky130_fd_pr__nfet_01v8_SWJJUK_2/S1 0.19918f
C19 sky130_fd_pr__nfet_01v8_SWJJUK_2/D0 BIAS_N 0
C20 sky130_fd_pr__pfet_01v8_LBPW5X_mod1_0/D0 VSS 0
C21 BIAS_P sky130_fd_pr__pfet_01v8_LBPW5X_mod1_0/D0 0.48384f
C22 VDD sky130_fd_pr__pfet_01v8_LBPW5X_mod1_0/D0 0.964f
C23 sky130_fd_pr__pfet_01v8_LBPW5X_mod1_0/D0 sky130_fd_pr__pfet_01v8_PB76X2_2/S 0.0691f
C24 VSS BIAS_N 0.1015f
C25 BIAS_P BIAS_N 0.68976f
C26 sky130_fd_pr__nfet_01v8_SWJJUK_2/D0 sky130_fd_pr__pfet_01v8_3CBY59_2/D 0.47343f
C27 VDD BIAS_N 0.35659f
C28 sky130_fd_pr__nfet_01v8_SWJJUK_3/D0 sky130_fd_pr__nfet_01v8_SWJJUK_2/D0 1.02411f
C29 sky130_fd_pr__nfet_01v8_SWJJUK_2/D0 sky130_fd_pr__nfet_01v8_SWJJUK_2/S1 0.04734f
C30 sky130_fd_pr__pfet_01v8_PB76X2_2/S BIAS_N 0
C31 VSS sky130_fd_pr__pfet_01v8_3CBY59_2/D 0.6534f
C32 BIAS_P sky130_fd_pr__pfet_01v8_3CBY59_2/D 0.36004f
C33 sky130_fd_pr__nfet_01v8_SWJJUK_3/D0 VSS 0.57405f
C34 sky130_fd_pr__nfet_01v8_SWJJUK_3/D0 BIAS_P 0.06212f
C35 VSS sky130_fd_pr__nfet_01v8_SWJJUK_2/S1 0.37107f
C36 BIAS_P sky130_fd_pr__nfet_01v8_SWJJUK_2/S1 0.04026f
C37 VDD sky130_fd_pr__pfet_01v8_3CBY59_2/D 0.37246f
C38 sky130_fd_pr__nfet_01v8_SWJJUK_3/D0 VDD 0.03924f
C39 sky130_fd_pr__pfet_01v8_LBPW5X_mod1_0/D0 BIAS_N 0.00422f
C40 VDD sky130_fd_pr__nfet_01v8_SWJJUK_2/S1 0.0082f
C41 sky130_fd_pr__pfet_01v8_3CBY59_2/D sky130_fd_pr__pfet_01v8_PB76X2_2/S 0.0165f
C42 sky130_fd_pr__nfet_01v8_SWJJUK_3/D0 sky130_fd_pr__pfet_01v8_PB76X2_2/S 0.00185f
C43 sky130_fd_pr__pfet_01v8_3CBY59_2/D 0 2.35677f
C44 BIAS_P 0 2.36758f
C45 sky130_fd_pr__nfet_01v8_SWJJUK_3/D0 0 1.23374f
C46 sky130_fd_pr__nfet_01v8_SWJJUK_2/D0 0 0.35666f
C47 VSS 0 0.96395f
C48 VDD 0 14.9936f
C49 sky130_fd_pr__pfet_01v8_PB76X2_2/S 0 0.10197f
C50 sky130_fd_pr__pfet_01v8_LBPW5X_mod1_0/D0 0 0.19165f
C51 sky130_fd_pr__nfet_01v8_SWJJUK_2/S1 0 1.34016f
C52 BIAS_N 0 1.89752f
.ends

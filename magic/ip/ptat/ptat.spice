* SPICE3 file created from ptat.ext - technology: sky130A

.subckt sky130_fd_pr__nfet_01v8_KXES5E D0 G S1 a_129_n169# VSUBS
X0 a_129_n169# G S1 VSUBS sky130_fd_pr__nfet_01v8 ad=0.58 pd=4.58 as=0.29 ps=2.29 w=2 l=0.5
X1 S1 G D0 VSUBS sky130_fd_pr__nfet_01v8 ad=0.29 pd=2.29 as=0.58 ps=4.58 w=2 l=0.5
C0 S1 D0 0.17948f
C1 S1 G 0.10052f
C2 D0 G 0.05026f
C3 S1 a_129_n169# 0.17948f
C4 G a_129_n169# 0.05026f
C5 S1 VSUBS 0.04825f
C6 D0 VSUBS 0.20369f
C7 G VSUBS 0.58972f
C8 a_129_n169# VSUBS 0.20369f
.ends

.subckt sky130_fd_pr__nfet_01v8_44FS3R B D0 G S1 a_179_n281#
X0 S1 G D0 B sky130_fd_pr__nfet_01v8 ad=0.3625 pd=2.79 as=0.725 ps=5.58 w=2.5 l=0.75
X1 a_179_n281# G S1 B sky130_fd_pr__nfet_01v8 ad=0.725 pd=5.58 as=0.3625 ps=2.79 w=2.5 l=0.75
C0 S1 D0 0.17037f
C1 S1 a_179_n281# 0.17037f
C2 S1 G 0.14f
C3 D0 G 0.07f
C4 G a_179_n281# 0.07f
C5 S1 B 0.07399f
C6 D0 B 0.3023f
C7 G B 0.85441f
C8 a_179_n281# B 0.3023f
.ends

.subckt sky130_fd_pr__res_xhigh_po_0p35_S4LC8G R1 R2 VSUBS
X0 R1 R2 VSUBS sky130_fd_pr__res_xhigh_po_0p35 l=2.65
C0 R2 R1 0.00737f
C1 R2 VSUBS 0.58514f
C2 R1 VSUBS 0.58514f
.ends

.subckt sky130_fd_pr__nfet_01v8_SWJJUK D0 G S1 a_129_n231# VSUBS
X0 S1 G D0 VSUBS sky130_fd_pr__nfet_01v8 ad=0.29 pd=2.29 as=0.58 ps=4.58 w=2 l=0.5
X1 a_129_n231# G S1 VSUBS sky130_fd_pr__nfet_01v8 ad=0.58 pd=4.58 as=0.29 ps=2.29 w=2 l=0.5
C0 S1 D0 0.17948f
C1 S1 G 0.10052f
C2 D0 G 0.05026f
C3 S1 a_129_n231# 0.17948f
C4 G a_129_n231# 0.05026f
C5 S1 VSUBS 0.04825f
C6 D0 VSUBS 0.20369f
C7 G VSUBS 0.58972f
C8 a_129_n231# VSUBS 0.20369f
.ends

.subckt sky130_fd_pr__pfet_01v8_3CTS57_mod1 D0 G S1 a_129_n236# w_n223_n298# VSUBS
X0 a_129_n236# G S1 w_n223_n298# sky130_fd_pr__pfet_01v8 ad=0.58 pd=4.58 as=0.29 ps=2.29 w=2 l=0.5
X1 S1 G D0 w_n223_n298# sky130_fd_pr__pfet_01v8 ad=0.29 pd=2.29 as=0.58 ps=4.58 w=2 l=0.5
C0 D0 S1 0.17948f
C1 G S1 0.09632f
C2 D0 G 0.02964f
C3 a_129_n236# S1 0.17948f
C4 w_n223_n298# S1 0.00361f
C5 G a_129_n236# 0.02964f
C6 D0 w_n223_n298# 0.01048f
C7 G w_n223_n298# 0.15044f
C8 a_129_n236# w_n223_n298# 0.01048f
C9 S1 VSUBS 0.04491f
C10 D0 VSUBS 0.20076f
C11 G VSUBS 0.42604f
C12 a_129_n236# VSUBS 0.20076f
C13 w_n223_n298# VSUBS 0.75196f
.ends

.subckt sky130_fd_pr__pfet_01v8_5AWAJG B D S G VSUBS
X0 S G D B sky130_fd_pr__pfet_01v8 ad=0.29 pd=2.58 as=0.29 ps=2.58 w=1 l=14
C0 S G 0.04934f
C1 D G 0.04934f
C2 S B 0.08756f
C3 D B 0.08756f
C4 G B 3.18552f
C5 S VSUBS 0.09221f
C6 D VSUBS 0.09221f
C7 G VSUBS 3.27161f
C8 B VSUBS 7.37273f
.ends

.subckt sky130_fd_pr__pfet_01v8_LBPW5X_mod1 D0 G S1 w_n223_n264# a_129_n164# VSUBS
X0 a_129_n164# G S1 w_n223_n264# sky130_fd_pr__pfet_01v8 ad=0.58 pd=4.58 as=0.29 ps=2.29 w=2 l=0.5
X1 S1 G D0 w_n223_n264# sky130_fd_pr__pfet_01v8 ad=0.29 pd=2.29 as=0.58 ps=4.58 w=2 l=0.5
C0 D0 S1 0.17948f
C1 G S1 0.09632f
C2 D0 G 0.02964f
C3 a_129_n164# S1 0.17948f
C4 w_n223_n264# S1 0.00361f
C5 G a_129_n164# 0.02964f
C6 D0 w_n223_n264# 0.01048f
C7 G w_n223_n264# 0.15044f
C8 a_129_n164# w_n223_n264# 0.01048f
C9 S1 VSUBS 0.04491f
C10 D0 VSUBS 0.20076f
C11 G VSUBS 0.42604f
C12 a_129_n164# VSUBS 0.20076f
C13 w_n223_n264# VSUBS 0.75196f
.ends

.subckt sky130_fd_pr__pfet_01v8_57LS5R B D0 G S1 D2 S3 D4 S4 VSUBS
X0 S3 G D2 B sky130_fd_pr__pfet_01v8 ad=0.29 pd=2.29 as=0.29 ps=2.29 w=2 l=0.75
X1 S4 G D4 B sky130_fd_pr__pfet_01v8 ad=0.58 pd=4.58 as=0.29 ps=2.29 w=2 l=0.75
X2 D4 G S3 B sky130_fd_pr__pfet_01v8 ad=0.29 pd=2.29 as=0.29 ps=2.29 w=2 l=0.75
X3 S1 G D0 B sky130_fd_pr__pfet_01v8 ad=0.29 pd=2.29 as=0.58 ps=4.58 w=2 l=0.75
X4 D2 G S1 B sky130_fd_pr__pfet_01v8 ad=0.29 pd=2.29 as=0.29 ps=2.29 w=2 l=0.75
C0 S1 D2 0.13656f
C1 D4 S4 0.13656f
C2 B S4 0.14402f
C3 S1 D0 0.13656f
C4 G S3 0.11803f
C5 G D2 0.11803f
C6 D4 S3 0.13656f
C7 B S3 0.01465f
C8 B D2 0.01465f
C9 S1 G 0.11803f
C10 D0 G 0.05902f
C11 S1 B 0.01465f
C12 D0 B 0.14402f
C13 D4 G 0.11803f
C14 G B 1.11891f
C15 D2 S3 0.13656f
C16 D4 B 0.01465f
C17 G S4 0.05902f
C18 S4 VSUBS 0.10392f
C19 D4 VSUBS 0.0486f
C20 S3 VSUBS 0.0486f
C21 D2 VSUBS 0.0486f
C22 S1 VSUBS 0.0486f
C23 D0 VSUBS 0.10392f
C24 G VSUBS 0.93282f
C25 B VSUBS 4.1935f
.ends

.subckt sky130_fd_pr__pfet_01v8_3CBY59 D S G w_n144_n298# VSUBS
X0 S G D w_n144_n298# sky130_fd_pr__pfet_01v8 ad=0.58 pd=4.58 as=0.58 ps=4.58 w=2 l=0.5
C0 G S 0.02866f
C1 G D 0.02866f
C2 w_n144_n298# S 0.01048f
C3 w_n144_n298# D 0.01048f
C4 G w_n144_n298# 0.08002f
C5 D S 0.17948f
C6 S VSUBS 0.20076f
C7 D VSUBS 0.20076f
C8 G VSUBS 0.22612f
C9 w_n144_n298# VSUBS 0.48557f
.ends

.subckt sky130_fd_pr__pfet_01v8_PB76X2 D S G w_n144_n264# VSUBS
X0 S G D w_n144_n264# sky130_fd_pr__pfet_01v8 ad=0.58 pd=4.58 as=0.58 ps=4.58 w=2 l=0.5
C0 G S 0.02866f
C1 G D 0.02866f
C2 w_n144_n264# S 0.01048f
C3 w_n144_n264# D 0.01048f
C4 G w_n144_n264# 0.08002f
C5 D S 0.17948f
C6 S VSUBS 0.20076f
C7 D VSUBS 0.20076f
C8 G VSUBS 0.22612f
C9 w_n144_n264# VSUBS 0.48557f
.ends

.subckt ptat VDD VSS BIAS_P BIAS_N
Xsky130_fd_pr__nfet_01v8_KXES5E_4 VSS VSS VSS VSS VSS sky130_fd_pr__nfet_01v8_KXES5E
Xsky130_fd_pr__nfet_01v8_44FS3R_0 VSS VSS BIAS_N BIAS_N VSS sky130_fd_pr__nfet_01v8_44FS3R
Xsky130_fd_pr__res_xhigh_po_0p35_S4LC8G_0 sky130_fd_pr__nfet_01v8_SWJJUK_2/S1 VSS
+ VSS sky130_fd_pr__res_xhigh_po_0p35_S4LC8G
Xsky130_fd_pr__nfet_01v8_SWJJUK_0 VSS VSS VSS VSS VSS sky130_fd_pr__nfet_01v8_SWJJUK
Xsky130_fd_pr__nfet_01v8_SWJJUK_1 sky130_fd_pr__nfet_01v8_SWJJUK_3/D0 sky130_fd_pr__pfet_01v8_5AWAJG_0/D
+ sky130_fd_pr__pfet_01v8_5AWAJG_0/D sky130_fd_pr__nfet_01v8_SWJJUK_3/D0 VSS sky130_fd_pr__nfet_01v8_SWJJUK
Xsky130_fd_pr__nfet_01v8_SWJJUK_2 sky130_fd_pr__nfet_01v8_SWJJUK_2/D0 sky130_fd_pr__pfet_01v8_5AWAJG_0/D
+ sky130_fd_pr__nfet_01v8_SWJJUK_2/S1 sky130_fd_pr__nfet_01v8_SWJJUK_2/D0 VSS sky130_fd_pr__nfet_01v8_SWJJUK
Xsky130_fd_pr__nfet_01v8_SWJJUK_3 sky130_fd_pr__nfet_01v8_SWJJUK_3/D0 sky130_fd_pr__pfet_01v8_5AWAJG_0/D
+ sky130_fd_pr__pfet_01v8_5AWAJG_0/D sky130_fd_pr__nfet_01v8_SWJJUK_3/D0 VSS sky130_fd_pr__nfet_01v8_SWJJUK
Xsky130_fd_pr__nfet_01v8_SWJJUK_4 VSS VSS VSS VSS VSS sky130_fd_pr__nfet_01v8_SWJJUK
Xsky130_fd_pr__pfet_01v8_3CTS57_mod1_0 sky130_fd_pr__pfet_01v8_LBPW5X_mod1_0/D0 BIAS_P
+ VDD sky130_fd_pr__pfet_01v8_LBPW5X_mod1_0/D0 VDD VSS sky130_fd_pr__pfet_01v8_3CTS57_mod1
Xsky130_fd_pr__pfet_01v8_5AWAJG_0 VDD sky130_fd_pr__pfet_01v8_5AWAJG_0/D VDD VSS VSS
+ sky130_fd_pr__pfet_01v8_5AWAJG
Xsky130_fd_pr__pfet_01v8_LBPW5X_mod1_0 sky130_fd_pr__pfet_01v8_LBPW5X_mod1_0/D0 BIAS_P
+ BIAS_P VDD sky130_fd_pr__pfet_01v8_LBPW5X_mod1_0/D0 VSS sky130_fd_pr__pfet_01v8_LBPW5X_mod1
Xsky130_fd_pr__pfet_01v8_57LS5R_0 VDD VDD BIAS_P BIAS_N VDD BIAS_N VDD BIAS_N VSS
+ sky130_fd_pr__pfet_01v8_57LS5R
Xsky130_fd_pr__pfet_01v8_3CBY59_0 sky130_fd_pr__pfet_01v8_PB76X2_2/S sky130_fd_pr__pfet_01v8_5AWAJG_0/D
+ BIAS_P VDD VSS sky130_fd_pr__pfet_01v8_3CBY59
Xsky130_fd_pr__pfet_01v8_3CBY59_1 VDD VDD VDD VDD VSS sky130_fd_pr__pfet_01v8_3CBY59
Xsky130_fd_pr__pfet_01v8_PB76X2_0 sky130_fd_pr__pfet_01v8_PB76X2_2/S VDD BIAS_P VDD
+ VSS sky130_fd_pr__pfet_01v8_PB76X2
Xsky130_fd_pr__pfet_01v8_3CBY59_2 sky130_fd_pr__pfet_01v8_5AWAJG_0/D sky130_fd_pr__pfet_01v8_PB76X2_2/S
+ BIAS_P VDD VSS sky130_fd_pr__pfet_01v8_3CBY59
Xsky130_fd_pr__pfet_01v8_PB76X2_1 VDD VDD VDD VDD VSS sky130_fd_pr__pfet_01v8_PB76X2
Xsky130_fd_pr__pfet_01v8_3CBY59_3 VDD VDD VDD VDD VSS sky130_fd_pr__pfet_01v8_3CBY59
Xsky130_fd_pr__pfet_01v8_PB76X2_2 VDD sky130_fd_pr__pfet_01v8_PB76X2_2/S BIAS_P VDD
+ VSS sky130_fd_pr__pfet_01v8_PB76X2
Xsky130_fd_pr__pfet_01v8_PB76X2_3 VDD VDD VDD VDD VSS sky130_fd_pr__pfet_01v8_PB76X2
Xsky130_fd_pr__nfet_01v8_KXES5E_0 VSS VSS VSS VSS VSS sky130_fd_pr__nfet_01v8_KXES5E
Xsky130_fd_pr__nfet_01v8_KXES5E_1 sky130_fd_pr__nfet_01v8_SWJJUK_3/D0 sky130_fd_pr__pfet_01v8_5AWAJG_0/D
+ VSS sky130_fd_pr__nfet_01v8_SWJJUK_3/D0 VSS sky130_fd_pr__nfet_01v8_KXES5E
Xsky130_fd_pr__nfet_01v8_KXES5E_2 sky130_fd_pr__nfet_01v8_SWJJUK_2/D0 sky130_fd_pr__pfet_01v8_5AWAJG_0/D
+ BIAS_P sky130_fd_pr__nfet_01v8_SWJJUK_2/D0 VSS sky130_fd_pr__nfet_01v8_KXES5E
Xsky130_fd_pr__nfet_01v8_KXES5E_3 sky130_fd_pr__nfet_01v8_SWJJUK_3/D0 sky130_fd_pr__pfet_01v8_5AWAJG_0/D
+ VSS sky130_fd_pr__nfet_01v8_SWJJUK_3/D0 VSS sky130_fd_pr__nfet_01v8_KXES5E
C0 BIAS_N VDD 0.35476f
C1 sky130_fd_pr__nfet_01v8_SWJJUK_2/S1 BIAS_N 0.10631f
C2 sky130_fd_pr__pfet_01v8_PB76X2_2/S VSS 0.00381f
C3 sky130_fd_pr__pfet_01v8_LBPW5X_mod1_0/D0 BIAS_N 0.00422f
C4 sky130_fd_pr__pfet_01v8_5AWAJG_0/D VSS 1.13743f
C5 sky130_fd_pr__nfet_01v8_SWJJUK_2/D0 BIAS_N 0
C6 BIAS_P VSS 0.1782f
C7 BIAS_N sky130_fd_pr__nfet_01v8_SWJJUK_3/D0 0.00199f
C8 VSS VDD 1.78918f
C9 sky130_fd_pr__nfet_01v8_SWJJUK_2/S1 VSS 0.37133f
C10 sky130_fd_pr__pfet_01v8_LBPW5X_mod1_0/D0 VSS 0.01988f
C11 sky130_fd_pr__nfet_01v8_SWJJUK_2/D0 VSS 0.083f
C12 sky130_fd_pr__pfet_01v8_5AWAJG_0/D sky130_fd_pr__pfet_01v8_PB76X2_2/S 0.04521f
C13 VSS sky130_fd_pr__nfet_01v8_SWJJUK_3/D0 1.00366f
C14 sky130_fd_pr__pfet_01v8_PB76X2_2/S BIAS_P 1.19226f
C15 sky130_fd_pr__pfet_01v8_5AWAJG_0/D BIAS_P 0.46224f
C16 sky130_fd_pr__pfet_01v8_PB76X2_2/S VDD 1.40026f
C17 sky130_fd_pr__pfet_01v8_5AWAJG_0/D VDD 1.3654f
C18 sky130_fd_pr__pfet_01v8_5AWAJG_0/D sky130_fd_pr__nfet_01v8_SWJJUK_2/S1 0.14266f
C19 sky130_fd_pr__pfet_01v8_LBPW5X_mod1_0/D0 sky130_fd_pr__pfet_01v8_PB76X2_2/S 0.0691f
C20 sky130_fd_pr__pfet_01v8_LBPW5X_mod1_0/D0 sky130_fd_pr__pfet_01v8_5AWAJG_0/D 0.56813f
C21 BIAS_P VDD 1.92573f
C22 sky130_fd_pr__nfet_01v8_SWJJUK_2/S1 BIAS_P 0.04026f
C23 sky130_fd_pr__nfet_01v8_SWJJUK_2/D0 sky130_fd_pr__pfet_01v8_PB76X2_2/S 0
C24 sky130_fd_pr__pfet_01v8_5AWAJG_0/D sky130_fd_pr__nfet_01v8_SWJJUK_2/D0 0.39288f
C25 sky130_fd_pr__pfet_01v8_LBPW5X_mod1_0/D0 BIAS_P 0.48384f
C26 sky130_fd_pr__nfet_01v8_SWJJUK_2/S1 VDD 0.00836f
C27 sky130_fd_pr__nfet_01v8_SWJJUK_2/D0 BIAS_P 0.03409f
C28 sky130_fd_pr__pfet_01v8_PB76X2_2/S sky130_fd_pr__nfet_01v8_SWJJUK_3/D0 0.00185f
C29 sky130_fd_pr__pfet_01v8_LBPW5X_mod1_0/D0 VDD 0.96783f
C30 sky130_fd_pr__pfet_01v8_5AWAJG_0/D sky130_fd_pr__nfet_01v8_SWJJUK_3/D0 1.04309f
C31 VSS BIAS_N 0.19906f
C32 sky130_fd_pr__nfet_01v8_SWJJUK_2/D0 VDD 0.00333f
C33 sky130_fd_pr__nfet_01v8_SWJJUK_2/S1 sky130_fd_pr__nfet_01v8_SWJJUK_2/D0 0.04734f
C34 BIAS_P sky130_fd_pr__nfet_01v8_SWJJUK_3/D0 0.06268f
C35 sky130_fd_pr__pfet_01v8_LBPW5X_mod1_0/D0 sky130_fd_pr__nfet_01v8_SWJJUK_2/D0 0.00473f
C36 VDD sky130_fd_pr__nfet_01v8_SWJJUK_3/D0 0.0391f
C37 sky130_fd_pr__nfet_01v8_SWJJUK_2/S1 sky130_fd_pr__nfet_01v8_SWJJUK_3/D0 0.20191f
C38 sky130_fd_pr__pfet_01v8_LBPW5X_mod1_0/D0 sky130_fd_pr__nfet_01v8_SWJJUK_3/D0 0.02409f
C39 sky130_fd_pr__nfet_01v8_SWJJUK_2/D0 sky130_fd_pr__nfet_01v8_SWJJUK_3/D0 1.48011f
C40 sky130_fd_pr__pfet_01v8_PB76X2_2/S BIAS_N 0
C41 sky130_fd_pr__pfet_01v8_5AWAJG_0/D BIAS_N 0
C42 BIAS_P BIAS_N 0.68645f
C43 sky130_fd_pr__pfet_01v8_5AWAJG_0/D 0 3.36613f
C44 BIAS_P 0 2.24074f
C45 sky130_fd_pr__nfet_01v8_SWJJUK_2/D0 0 0.23818f
C46 sky130_fd_pr__nfet_01v8_SWJJUK_3/D0 0 1.24526f
C47 VSS 0 2.77442f
C48 VDD 0 21.56781f
C49 sky130_fd_pr__pfet_01v8_PB76X2_2/S 0 0.10061f
C50 sky130_fd_pr__pfet_01v8_LBPW5X_mod1_0/D0 0 0.1486f
C51 sky130_fd_pr__nfet_01v8_SWJJUK_2/S1 0 1.33235f
C52 BIAS_N 0 2.04199f
.ends
